* SUB_SYSTEM PFM_V13: V12 (no VREF_PFM filter, RFB2_BOT=7.527K) + CVREF=390p on VREF; UNVALIDATED
.lib '/home/114B01/Desktop/TECH/models/hspice/toplevel.l' t18_tt
.UNPROTECT

.OPTION POST=1
.OPTION PROBE=1
.OPTION INTERP=1   $ 1ns saved grid; consecutive periods remain measured directly

.OPTION METHOD=GEAR
.OPTION RUNLVL=5
.OPTION GMINDC=1p
.OPTION RELTOL=1e-4
.OPTION ABSTOL=1e-12
.OPTION VNTOL=1u
.OPTION ITL1=500
.OPTION ITL2=1000
.OPTION ITL4=100

.INCLUDE 'sub_system.net'

VVDD       VDD       GND       DC 3.3

X_SYS      VDD GND VOUT MPC MNC   SUB

ILOAD_STEP VOUT GND PULSE(50m 500m 32u 100n 100n 20u 200u)

.IC V(X_SYS.XBGR_SS.XSOFT.VC1)=0V
.IC V(VOUT)=0
.IC V(X_SYS.XTRIANGO_HZ.N_C1)=0
.IC V(X_SYS.S1)=0
.IC V(X_SYS.ZCD_PFM)=0
.IC V(X_SYS.PFM_IDLE)=0
.IC V(X_SYS.XPFM_DIODE.IDLE_B)=3.3
.IC V(X_SYS.XPFM_DIODE.BL_RC)=3.3
.IC V(X_SYS.PFM_Q)=0
.IC V(X_SYS.PFM_QB)=3.3
.IC V(X_SYS.VDUTY_SEL)=3.3
.IC V(X_SYS.VCOMP)=1.2
.IC V(X_SYS.XPWM_OSC.RAMP)=0
.IC V(X_SYS.MODE)=0
.IC V(X_SYS.PG)=0
.IC V(X_SYS.XMODE_DET.N_TMR)=0
.IC V(X_SYS.XMODE_DET.ZCD_RAW)=0
.IC V(X_SYS.XMODE_DET.ZCD_VALID)=0
.IC V(X_SYS.XMODE_DET.ARMED)=0
.IC V(X_SYS.XMODE_DET.ARMEDB)=3.3

.PROBE TRAN V(X_SYS.TRIANGO_HZ.RAMP_RST)
.PROBE TRAN V(VOUT) V(X_SYS.VREF) V(X_SYS.XBGR_SS.XSOFT.VBUF) V(X_SYS.XBGR_SS.XSOFT.VC1)
.PROBE TRAN V(X_SYS.XBUCK.SW) V(MPC) V(MNC)
.PROBE TRAN I(VVDD) I(ILOAD_STEP) I(X_SYS.XBUCK.L1)
.PROBE TRAN V(X_SYS.VCOMP) V(X_SYS.RAMP)
.PROBE TRAN V(X_SYS.XPWM_OSC.CLK)
.PROBE TRAN V(X_SYS.MODE) V(X_SYS.VDUTY_SEL)
.PROBE TRAN V(X_SYS.XMODE_DET.N_TMR) V(X_SYS.XMODE_DET.ZCD_RAW) V(X_SYS.XMODE_DET.ZCD_LS)
.PROBE TRAN V(X_SYS.XMODE_DET.ZCD_VALID) V(X_SYS.XMODE_DET.MNC_GATE)
.PROBE TRAN V(X_SYS.PG) V(X_SYS.XMODE_DET.PG_B) V(X_SYS.XMODE_DET.ARMED) V(X_SYS.XMODE_DET.ARMEDB)

.PROBE TRAN V(X_SYS.VBIAS_BGR)   V(X_SYS.VBIAS_CMP01) V(X_SYS.VBIAS_TRI)
.PROBE TRAN V(X_SYS.VBIAS_EA)    V(X_SYS.VBIAS_PWMOSC) V(X_SYS.VBIAS_PWMCMP)
.PROBE TRAN V(X_SYS.VBIAS_PG)    V(X_SYS.VBIAS_MODE)

* PFM v4 trigger, energy-per-pulse and low-side shutdown diagnostics.
.PROBE TRAN V(X_SYS.VOUTR2) V(X_SYS.VREF_FIX)
.PROBE TRAN V(X_SYS.S1) V(X_SYS.PFM_Q) V(X_SYS.PFM_QB) V(X_SYS.RAMP_RST)
.PROBE TRAN V(X_SYS.XTRIANGO_HZ.N_C1) V(X_SYS.SW_PFM_ZCD) V(X_SYS.ZCD_PFM)
.PROBE TRAN V(X_SYS.PFM_IDLE) V(X_SYS.PFM_LS_ALLOW) V(X_SYS.VN_RAW_DEAD) V(X_SYS.VP_RAW_DEAD)
.PROBE TRAN V(X_SYS.XPFM_DIODE.LS_VALID) V(X_SYS.XPFM_DIODE.STOP_SET)
.PROBE TRAN V(X_SYS.XMODE_DET.ZCD_SEEN)
.PROBE TRAN V(X_SYS.XBUCK.N_SNUB)
.PROBE TRAN V(X_SYS.XBUCK.C1N) V(VOUT,X_SYS.XBUCK.C1N)

.TRAN 1n 80u UIC

.PARAM VNOM=1.800

.MEAS TRAN T_VOUT_RISE   WHEN V(VOUT)=1.8   RISE=1
.MEAS TRAN T_VOUT_RISE99 WHEN V(VOUT)=1.782 RISE=1
.MEAS TRAN T_VREF_SETTLE WHEN V(X_SYS.VREF)=1.14 RISE=1
.MEAS TRAN VOUT_PEAK     MAX V(VOUT) FROM=8u  TO=32u
.MEAS TRAN VOUT_OS_PCT   PARAM='(VOUT_PEAK-VNOM)/VNOM*100'

.MEAS TRAN VREF_ACTUAL_AVG AVG V(X_SYS.VREF) FROM=26u TO=31u
.MEAS TRAN VREF_ACTUAL_MIN MIN V(X_SYS.VREF) FROM=26u TO=31u
.MEAS TRAN VREF_ACTUAL_MAX MAX V(X_SYS.VREF) FROM=26u TO=31u
.MEAS TRAN VREF_RIPPLE_PP  PARAM='VREF_ACTUAL_MAX-VREF_ACTUAL_MIN'

.MEAS TRAN VOUT_AVG_HEAVY AVG V(VOUT) FROM=42u TO=51u
.MEAS TRAN VOUT_AVG_LIGHT AVG V(VOUT) FROM=62u TO=71u
.MEAS TRAN LOAD_REG_PCT PARAM='ABS(VOUT_AVG_HEAVY-VOUT_AVG_LIGHT)/VOUT_AVG_LIGHT*100'

* Non-invasive PWM frequency check: average over 16 cycles after startup
.MEAS TRAN PWM_SPAN16 TRIG V(X_SYS.XPWM_OSC.CLK) VAL=1.65 RISE=1 TD=42u
+ TARG V(X_SYS.XPWM_OSC.CLK) VAL=1.65 RISE=17 TD=42u
.MEAS TRAN PWM_PERIOD PARAM='PWM_SPAN16/16'
.MEAS TRAN PWM_FREQ_MHZ PARAM='16e-6/PWM_SPAN16'

* Consecutive PWM periods: use these to distinguish real jitter from plotting.
.MEAS TRAN PWM_PER1 TRIG V(X_SYS.XPWM_OSC.CLK) VAL=1.65 RISE=1 TD=42u
+ TARG V(X_SYS.XPWM_OSC.CLK) VAL=1.65 RISE=2 TD=42u
.MEAS TRAN PWM_PER2 TRIG V(X_SYS.XPWM_OSC.CLK) VAL=1.65 RISE=2 TD=42u
+ TARG V(X_SYS.XPWM_OSC.CLK) VAL=1.65 RISE=3 TD=42u
.MEAS TRAN PWM_PER3 TRIG V(X_SYS.XPWM_OSC.CLK) VAL=1.65 RISE=3 TD=42u
+ TARG V(X_SYS.XPWM_OSC.CLK) VAL=1.65 RISE=4 TD=42u
.MEAS TRAN PWM_PER4 TRIG V(X_SYS.XPWM_OSC.CLK) VAL=1.65 RISE=4 TD=42u
+ TARG V(X_SYS.XPWM_OSC.CLK) VAL=1.65 RISE=5 TD=42u
.MEAS TRAN PWM_PER5 TRIG V(X_SYS.XPWM_OSC.CLK) VAL=1.65 RISE=5 TD=42u
+ TARG V(X_SYS.XPWM_OSC.CLK) VAL=1.65 RISE=6 TD=42u
.MEAS TRAN PWM_PER6 TRIG V(X_SYS.XPWM_OSC.CLK) VAL=1.65 RISE=6 TD=42u
+ TARG V(X_SYS.XPWM_OSC.CLK) VAL=1.65 RISE=7 TD=42u
.MEAS TRAN PWM_PER7 TRIG V(X_SYS.XPWM_OSC.CLK) VAL=1.65 RISE=7 TD=42u
+ TARG V(X_SYS.XPWM_OSC.CLK) VAL=1.65 RISE=8 TD=42u
.MEAS TRAN PWM_PER8 TRIG V(X_SYS.XPWM_OSC.CLK) VAL=1.65 RISE=8 TD=42u
+ TARG V(X_SYS.XPWM_OSC.CLK) VAL=1.65 RISE=9 TD=42u

.MEAS TRAN VCOMP_MIN_HEAVY MIN V(X_SYS.VCOMP) FROM=42u TO=51u
.MEAS TRAN VCOMP_MAX_HEAVY MAX V(X_SYS.VCOMP) FROM=42u TO=51u
.MEAS TRAN VCOMP_PP_HEAVY PARAM='VCOMP_MAX_HEAVY-VCOMP_MIN_HEAVY'
.MEAS TRAN VOUT_MIN_HEAVY MIN V(VOUT) FROM=42u TO=51u
.MEAS TRAN VOUT_MAX_HEAVY MAX V(VOUT) FROM=42u TO=51u
.MEAS TRAN VOUT_PP_HEAVY PARAM='VOUT_MAX_HEAVY-VOUT_MIN_HEAVY'
.MEAS TRAN VOUT_MAX_POST52 MAX V(VOUT) FROM=52u TO=60u
.MEAS TRAN VOUT_MIN_POST52 MIN V(VOUT) FROM=52u TO=60u
.MEAS TRAN VOUT_SWING_POST52 PARAM='VOUT_MAX_POST52-VOUT_MIN_POST52'

.PARAM VLOGIC_H=2.31
.PARAM VLOGIC_L=0.99
.MEAS TRAN MODE_MIN_LIGHT MIN V(X_SYS.MODE) FROM=62u TO=71u
.MEAS TRAN MODE_MAX_LIGHT MAX V(X_SYS.MODE) FROM=62u TO=71u
.MEAS TRAN MODE_MIN_HEAVY MIN V(X_SYS.MODE) FROM=42u TO=51u
.MEAS TRAN MODE_MAX_HEAVY MAX V(X_SYS.MODE) FROM=42u TO=51u
.MEAS TRAN T_MODE_RISE WHEN V(X_SYS.MODE)=2.31 RISE=1 TD=32u
.MEAS TRAN T_MODE_FALL WHEN V(X_SYS.MODE)=0.99 FALL=1 TD=52u
.MEAS TRAN MODE_RISE_DELAY PARAM='T_MODE_RISE-32u'
.MEAS TRAN MODE_FALL_DELAY PARAM='T_MODE_FALL-52u'
.MEAS TRAN MODE_MAX_PRE32 MAX V(X_SYS.MODE) FROM=0 TO=31.99u
.MEAS TRAN NTMR_MAX_PRE32 MAX V(X_SYS.XMODE_DET.N_TMR) FROM=0 TO=31.99u
.MEAS TRAN T_ARM WHEN V(X_SYS.XMODE_DET.ARMED)=2.31 RISE=1
.MEAS TRAN NTMR_MAX_PREARM MAX V(X_SYS.XMODE_DET.N_TMR) FROM=0 TO=22u

.MEAS TRAN VREF_AT_5U  FIND V(X_SYS.VREF) AT=5u
.MEAS TRAN VREF_AT_10U FIND V(X_SYS.VREF) AT=10u
.MEAS TRAN VREF_AT_15U FIND V(X_SYS.VREF) AT=15u
.MEAS TRAN VOUT_AT_28U FIND V(VOUT) AT=28u
.MEAS TRAN VOUT_AT_48U FIND V(VOUT) AT=48u
.MEAS TRAN VOUT_AT_70U FIND V(VOUT) AT=70u

.MEAS TRAN VB_BGR_AVG    AVG V(X_SYS.VBIAS_BGR)    FROM=60u TO=70u
.MEAS TRAN VB_CMP01_AVG  AVG V(X_SYS.VBIAS_CMP01)  FROM=60u TO=70u
.MEAS TRAN VB_TRI_AVG    AVG V(X_SYS.VBIAS_TRI)    FROM=60u TO=70u
.MEAS TRAN VB_EA_AVG     AVG V(X_SYS.VBIAS_EA)     FROM=60u TO=70u
.MEAS TRAN VB_PWMOSC_AVG AVG V(X_SYS.VBIAS_PWMOSC) FROM=60u TO=70u
.MEAS TRAN VB_PWMCMP_AVG AVG V(X_SYS.VBIAS_PWMCMP) FROM=60u TO=70u
.MEAS TRAN VB_PG_AVG     AVG V(X_SYS.VBIAS_PG)     FROM=60u TO=70u
.MEAS TRAN VB_MODE_AVG   AVG V(X_SYS.VBIAS_MODE)   FROM=60u TO=70u

* Version marker: PFM_REV must be 13 in the returned measurement file.
.MEAS TRAN PFM_REV PARAM='13'
.MEAS TRAN CAP_PP_LATE PP V(X_SYS.XBUCK.C1N) FROM=70u TO=79u
.MEAS TRAN ESR_PP_LATE PP V(VOUT,X_SYS.XBUCK.C1N) FROM=70u TO=79u
.MEAS TRAN VOUT_PP_LIGHT PP V(VOUT) FROM=62u TO=71u
.MEAS TRAN IL_MIN_LIGHT MIN I(X_SYS.XBUCK.L1) FROM=62u TO=71u
.MEAS TRAN IL_MAX_LIGHT MAX I(X_SYS.XBUCK.L1) FROM=62u TO=71u
.MEAS TRAN VREF_RAW_PP_LIGHT PP V(X_SYS.VREF) FROM=62u TO=71u
.MEAS TRAN PFM_LIGHT_PER1 TRIG V(MPC) VAL=1.65 FALL=1 TD=62u
+ TARG V(MPC) VAL=1.65 FALL=2 TD=62u
.MEAS TRAN PFM_LIGHT_PER2 TRIG V(MPC) VAL=1.65 FALL=2 TD=62u
+ TARG V(MPC) VAL=1.65 FALL=3 TD=62u
.MEAS TRAN PFM_LIGHT_PER3 TRIG V(MPC) VAL=1.65 FALL=3 TD=62u
+ TARG V(MPC) VAL=1.65 FALL=4 TD=62u
.MEAS TRAN PFM_LIGHT_PER4 TRIG V(MPC) VAL=1.65 FALL=4 TD=62u
+ TARG V(MPC) VAL=1.65 FALL=5 TD=62u
.MEAS TRAN PFM_LIGHT_PER5 TRIG V(MPC) VAL=1.65 FALL=5 TD=62u
+ TARG V(MPC) VAL=1.65 FALL=6 TD=62u
.MEAS TRAN PFM_LIGHT_PER6 TRIG V(MPC) VAL=1.65 FALL=6 TD=62u
+ TARG V(MPC) VAL=1.65 FALL=7 TD=62u
.MEAS TRAN PFM_LIGHT_PER7 TRIG V(MPC) VAL=1.65 FALL=7 TD=62u
+ TARG V(MPC) VAL=1.65 FALL=8 TD=62u
.MEAS TRAN PFM_LIGHT_PER8 TRIG V(MPC) VAL=1.65 FALL=8 TD=62u
+ TARG V(MPC) VAL=1.65 FALL=9 TD=62u
.MEAS TRAN VOUT_AVG_LATE AVG V(VOUT) FROM=70u TO=79u
.MEAS TRAN VOUT_PP_LATE PP V(VOUT) FROM=70u TO=79u
.MEAS TRAN IL_MIN_LATE MIN I(X_SYS.XBUCK.L1) FROM=70u TO=79u
.MEAS TRAN IL_MAX_LATE MAX I(X_SYS.XBUCK.L1) FROM=70u TO=79u
.MEAS TRAN VREF_RAW_PP_LATE PP V(X_SYS.VREF) FROM=70u TO=79u
.MEAS TRAN MODE_MAX_LATE MAX V(X_SYS.MODE) FROM=70u TO=79u
.MEAS TRAN PFM_LATE_PER1 TRIG V(MPC) VAL=1.65 FALL=1 TD=70u
+ TARG V(MPC) VAL=1.65 FALL=2 TD=70u
.MEAS TRAN PFM_LATE_PER2 TRIG V(MPC) VAL=1.65 FALL=2 TD=70u
+ TARG V(MPC) VAL=1.65 FALL=3 TD=70u
.MEAS TRAN PFM_LATE_PER3 TRIG V(MPC) VAL=1.65 FALL=3 TD=70u
+ TARG V(MPC) VAL=1.65 FALL=4 TD=70u
.MEAS TRAN PFM_LATE_PER4 TRIG V(MPC) VAL=1.65 FALL=4 TD=70u
+ TARG V(MPC) VAL=1.65 FALL=5 TD=70u
.MEAS TRAN PFM_LATE_PER5 TRIG V(MPC) VAL=1.65 FALL=5 TD=70u
+ TARG V(MPC) VAL=1.65 FALL=6 TD=70u
.MEAS TRAN PFM_LATE_PER6 TRIG V(MPC) VAL=1.65 FALL=6 TD=70u
+ TARG V(MPC) VAL=1.65 FALL=7 TD=70u
.MEAS TRAN PFM_LATE_PER7 TRIG V(MPC) VAL=1.65 FALL=7 TD=70u
+ TARG V(MPC) VAL=1.65 FALL=8 TD=70u
.MEAS TRAN PFM_LATE_PER8 TRIG V(MPC) VAL=1.65 FALL=8 TD=70u
+ TARG V(MPC) VAL=1.65 FALL=9 TD=70u
.MEAS TRAN VOUT_MIN_POST32 MIN V(VOUT) FROM=32u TO=42u
.MEAS TRAN VOUT_MIN_PRESTEP MIN V(VOUT) FROM=28u TO=31.9u
.MEAS TRAN VOUT_MAX_PRESTEP MAX V(VOUT) FROM=28u TO=31.9u
.MEAS TRAN PFM_IDLE_MAX MAX V(X_SYS.PFM_IDLE) FROM=62u TO=71u
.MEAS TRAN PFM_IDLE_MAX_HEAVY MAX V(X_SYS.PFM_IDLE) FROM=42u TO=51u

* Full light-load window: do not judge only a quiet 9us slice.
.MEAS TRAN VOUT_PP_LONG PP V(VOUT) FROM=62u TO=79u
.MEAS TRAN MODE_MAX_LONG MAX V(X_SYS.MODE) FROM=62u TO=79u
.MEAS TRAN IIN_AVG_LIGHT AVG I(VVDD) FROM=62u TO=71u
.MEAS TRAN IIN_AVG_HEAVY AVG I(VVDD) FROM=42u TO=51u
.MEAS TRAN IIN_AVG_LATE AVG I(VVDD) FROM=70u TO=79u
.MEAS TRAN PIN_AVG_LIGHT PARAM='-3.3*IIN_AVG_LIGHT'
.MEAS TRAN PIN_AVG_HEAVY PARAM='-3.3*IIN_AVG_HEAVY'
.MEAS TRAN PIN_AVG_LATE PARAM='-3.3*IIN_AVG_LATE'

.MEAS TRAN VOUT_AVG_LONG AVG V(VOUT) FROM=62u TO=79u

.END
